`include "disciplines.vams"

module TM2B_encoder_va(therm, binary);
    input [14:0] therm;
    output [3:0] binary;
    electrical [14:0] therm;
    electrical [3:0] binary;

    // 45nm Low-Voltage CMOS Parameters
    parameter real vhigh = 1.0;
    parameter real vlow  = 0.0;
    parameter real vth   = 0.5;
    parameter real td    = 8p;
    parameter real tr    = 10p;
    parameter real tf    = 10p;

    integer i, count;

    analog begin
        count = 0;
        for (i = 0; i <= 14; i = i + 1) begin
            if (V(therm[i]) > vth) begin
                count = count + 1;
            end
        end

        V(binary[0]) <+ transition((count & 4'b0001) ? vhigh : vlow, td, tr, tf);
        V(binary[1]) <+ transition((count & 4'b0010) ? vhigh : vlow, td, tr, tf);
        V(binary[2]) <+ transition((count & 4'b0100) ? vhigh : vlow, td, tr, tf);
        V(binary[3]) <+ transition((count & 4'b1000) ? vhigh : vlow, td, tr, tf);
    end
endmodule
