`include "disciplines.vams"

module bubble_remover_va(therm_raw, therm_clean);
    input [14:0] therm_raw;
    output [14:0] therm_clean;
    electrical [14:0] therm_raw, therm_clean;

    parameter real vhigh = 1.0;
    parameter real vlow  = 0.0;
    parameter real vth   = 0.5;
    parameter real td    = 5p;
    parameter real tr    = 10p;
    parameter real tf    = 10p;

    // Use genvar for indexing electrical nodes in loops
    genvar i;

    analog begin
        // Boundary bit 0
        V(therm_clean[0]) <+ transition((V(therm_raw[0]) > vth) ? vhigh : vlow, td, tr, tf);

        // Interior bits 1 through 13
        for (i = 1; i <= 13; i = i + 1) begin
            V(therm_clean[i]) <+ transition(
                ((V(therm_raw[i]) > vth) ||
                 ((V(therm_raw[i+1]) > vth) && (V(therm_raw[i-1]) > vth)))
                ? vhigh : vlow, td, tr, tf
            );
        end

        // Boundary bit 14
        V(therm_clean[14]) <+ transition((V(therm_raw[14]) > vth) ? vhigh : vlow, td, tr, tf);
    end
endmodule
